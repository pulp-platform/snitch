// Copyright 2020 ETH Zurich and University of Bologna.
// Solderpad Hardware License, Version 0.51, see LICENSE for details.
// SPDX-License-Identifier: SHL-0.51
// Licensed under Solderpad Hardware License, Version 0.51, see LICENSE for details.
{
  name: "occamy_quadrant_s1",
  clock_primary: "clk_i",
  bus_interfaces: [
    { protocol: "reg_iface", direction: "device" }
  ],
  regwidth: 32,
  registers: [

    { name: "CLK_ENA",
      desc: "Quadrant-internal clock gate enable",
      swaccess: "rw",
      hwaccess: "hro",
      // Clock disabled (i.e. gated) by default
      fields: [
        {bits: "0:0", name: "clk_ena", resval: 0, desc: "Clock gate enable"}
      ],
    },
    { name: "RESET_N",
      desc: "Quadrant-internal asynchronous active-low reset",
      swaccess: "rw",
      hwaccess: "hro",
      // *Not* held in reset (i.e. signal high) by default.
      // Since clock is gated on reset, inner quadrant state should *not* change until ungate.
      fields: [
        {bits: "0:0", name: "reset_n", resval: 1, desc: "Asynchronous active-low reset"}
      ]
    },
    { name: "ISOLATE",
      desc: "Isolate ports of given quadrant.",
      swaccess: "rw",
      hwaccess: "hro",
      // All channels isolated by default
      fields: [
        {bits: "0:0", name: "narrow_in",  resval: 1, desc: "narrow slave in isolate"},
        {bits: "1:1", name: "narrow_out", resval: 1, desc: "narrow master out isolate"},
        {bits: "2:2", name: "wide_in",    resval: 1, desc: "wide slave in isolate"},
        {bits: "3:3", name: "wide_out",   resval: 1, desc: "wide master out isolate"}
      ]
    },
    { name: "ISOLATED"
      desc: "Isolation status of S1 quadrant and port"
      swaccess: "ro"
      hwaccess: "hwo"
      hwqe: "true",
      hwext: "true",
      // All channels isolated by default
      fields: [
        {bits: "0:0", name: "narrow_in",  resval: 1, desc: "narrow slave in isolation status"},
        {bits: "1:1", name: "narrow_out", resval: 1, desc: "narrow master out isolation status"},
        {bits: "2:2", name: "wide_in",    resval: 1, desc: "wide slave in isolation status"},
        {bits: "3:3", name: "wide_out",   resval: 1, desc: "wide master out isolation status"}
      ]
    },
#// TODO: The enable registers below are unconditionally present; conditionalize on config?
    { name: "RO_CACHE_ENABLE",
      desc: "Enable read-only cache of quadrant.",
      swaccess: "rw",
      hwaccess: "hro",
      fields: [
        { bits: "0:0", resval: 0, name: "enable", desc: "Enable RO cache of S1 quadrant."}
      ]
    },
    { name: "RO_CACHE_FLUSH",
      desc: "Flush read-only cache.",
      swaccess: "rw"
      hwaccess: "hrw"
      fields: [
        { bits: "0:0", resval: 0, name: "flush", desc: "Flush (invalidate) RO cache of S1 quadrant."}
      ]
    },
    { name: "TLB_WIDE_ENABLE",
      desc: "Enable TLB on wide interface of quadrant.",
      swaccess: "rw",
      hwaccess: "hro",
      fields: [
        { bits: "0:0", resval: 0, name: "enable", desc: "Enable TLB on {t} interface."}
      ]
    },
    { name: "TLB_NARROW_ENABLE",
      desc: "Enable TLB on narrow interface of quadrant.",
      swaccess: "rw",
      hwaccess: "hro",
      fields: [
        { bits: "0:0", resval: 0, name: "enable", desc: "Enable TLB on {t} interface."}
      ]
    },

    // Start RO cache region fields at regular offset
    { skipto: "0x100" }
    { name: "RO_START_ADDR_LOW_0",
      desc: "Read-only cache start address low",
      swaccess: "rw",
      hwaccess: "hro",
      fields: [
        {bits: "31:0", name: "ADDR_LOW", desc: "Lower 32-bit of read-only region."}
      ]
    },
    { name: "RO_START_ADDR_HIGH_0",
      desc: "Read-only cache start address high",
      swaccess: "rw",
      hwaccess: "hro",
      fields: [
        {bits: "15:0", name: "ADDR_HIGH", resval: 0, desc: "Higher 32-bit of read-only region."}
      ]
    }
    { name: "RO_END_ADDR_LOW_0",
      desc: "Read-only cache end address low",
      swaccess: "rw",
      hwaccess: "hro",
      fields: [
        {bits: "31:0", name: "ADDR_LOW", desc: "Lower 32-bit of read-only region."}
      ]
    },
    { name: "RO_END_ADDR_HIGH_0",
      desc: "Read-only cache end address high",
      swaccess: "rw",
      hwaccess: "hro",
      fields: [
        {bits: "15:0", name: "ADDR_HIGH", resval: 1, desc: "Higher 32-bit of read-only region."}
      ]
    }
    { name: "RO_START_ADDR_LOW_1",
      desc: "Read-only cache start address low",
      swaccess: "rw",
      hwaccess: "hro",
      fields: [
        {bits: "31:0", name: "ADDR_LOW", desc: "Lower 32-bit of read-only region."}
      ]
    },
    { name: "RO_START_ADDR_HIGH_1",
      desc: "Read-only cache start address high",
      swaccess: "rw",
      hwaccess: "hro",
      fields: [
        {bits: "15:0", name: "ADDR_HIGH", resval: 1, desc: "Higher 32-bit of read-only region."}
      ]
    }
    { name: "RO_END_ADDR_LOW_1",
      desc: "Read-only cache end address low",
      swaccess: "rw",
      hwaccess: "hro",
      fields: [
        {bits: "31:0", name: "ADDR_LOW", desc: "Lower 32-bit of read-only region."}
      ]
    },
    { name: "RO_END_ADDR_HIGH_1",
      desc: "Read-only cache end address high",
      swaccess: "rw",
      hwaccess: "hro",
      fields: [
        {bits: "15:0", name: "ADDR_HIGH", resval: 2, desc: "Higher 32-bit of read-only region."}
      ]
    }
    { name: "RO_START_ADDR_LOW_2",
      desc: "Read-only cache start address low",
      swaccess: "rw",
      hwaccess: "hro",
      fields: [
        {bits: "31:0", name: "ADDR_LOW", desc: "Lower 32-bit of read-only region."}
      ]
    },
    { name: "RO_START_ADDR_HIGH_2",
      desc: "Read-only cache start address high",
      swaccess: "rw",
      hwaccess: "hro",
      fields: [
        {bits: "15:0", name: "ADDR_HIGH", resval: 2, desc: "Higher 32-bit of read-only region."}
      ]
    }
    { name: "RO_END_ADDR_LOW_2",
      desc: "Read-only cache end address low",
      swaccess: "rw",
      hwaccess: "hro",
      fields: [
        {bits: "31:0", name: "ADDR_LOW", desc: "Lower 32-bit of read-only region."}
      ]
    },
    { name: "RO_END_ADDR_HIGH_2",
      desc: "Read-only cache end address high",
      swaccess: "rw",
      hwaccess: "hro",
      fields: [
        {bits: "15:0", name: "ADDR_HIGH", resval: 3, desc: "Higher 32-bit of read-only region."}
      ]
    }
    { name: "RO_START_ADDR_LOW_3",
      desc: "Read-only cache start address low",
      swaccess: "rw",
      hwaccess: "hro",
      fields: [
        {bits: "31:0", name: "ADDR_LOW", desc: "Lower 32-bit of read-only region."}
      ]
    },
    { name: "RO_START_ADDR_HIGH_3",
      desc: "Read-only cache start address high",
      swaccess: "rw",
      hwaccess: "hro",
      fields: [
        {bits: "15:0", name: "ADDR_HIGH", resval: 3, desc: "Higher 32-bit of read-only region."}
      ]
    }
    { name: "RO_END_ADDR_LOW_3",
      desc: "Read-only cache end address low",
      swaccess: "rw",
      hwaccess: "hro",
      fields: [
        {bits: "31:0", name: "ADDR_LOW", desc: "Lower 32-bit of read-only region."}
      ]
    },
    { name: "RO_END_ADDR_HIGH_3",
      desc: "Read-only cache end address high",
      swaccess: "rw",
      hwaccess: "hro",
      fields: [
        {bits: "15:0", name: "ADDR_HIGH", resval: 4, desc: "Higher 32-bit of read-only region."}
      ]
    }

    // Start narrow TLB fields at regular offset
    { skipto: "0x800" }

    // narrow TLB entry 0
    { name: "TLB_NARROW_ENTRY_0_PAGEIN_FIRST_LOW",
      desc: "narrow TLB entry 0: Lower 32-bit of first page number of input range",
      swaccess: "rw",
      hwaccess: "hro",
      fields: [
        {bits: "31:0", name: "PAGEIN_FIRST_LOW", desc: "Lower 32-bit of first page number of input range"}
      ]
    },
    { name: "TLB_NARROW_ENTRY_0_PAGEIN_FIRST_HIGH",
      desc: "narrow TLB entry 0: Upper 32-bit of first page number of input range",
      swaccess: "rw",
      hwaccess: "hro",
      fields: [
        {bits: "3:0", name: "PAGEIN_FIRST_HIGH", desc: "Upper 32-bit of first page number of input range"}
      ]
    },
    { name: "TLB_NARROW_ENTRY_0_PAGEIN_LAST_LOW",
      desc: "narrow TLB entry 0: Lower 32-bit of last page (inclusive) number of input range",
      swaccess: "rw",
      hwaccess: "hro",
      fields: [
        {bits: "31:0", name: "PAGEIN_LAST_LOW", desc: "Lower 32-bit of last page (inclusive) number of input range"}
      ]
    },
    { name: "TLB_NARROW_ENTRY_0_PAGEIN_LAST_HIGH",
      desc: "narrow TLB entry 0: Upper 32-bit of last page (inclusive) number of input range",
      swaccess: "rw",
      hwaccess: "hro",
      fields: [
        {bits: "3:0", name: "PAGEIN_LAST_HIGH", desc: "Upper 32-bit of last page (inclusive) number of input range"}
      ]
    },
    { name: "TLB_NARROW_ENTRY_0_PAGEOUT_LOW",
      desc: "narrow TLB entry 0: Lower 32-bit of output base page",
      swaccess: "rw",
      hwaccess: "hro",
      fields: [
        {bits: "31:0", name: "PAGEOUT_LOW", desc: "Lower 32-bit of output base page"}
      ]
    },
    { name: "TLB_NARROW_ENTRY_0_PAGEOUT_HIGH",
      desc: "narrow TLB entry 0: Upper 32-bit of output base page",
      swaccess: "rw",
      hwaccess: "hro",
      fields: [
        {bits: "3:0", name: "PAGEOUT_HIGH", desc: "Upper 32-bit of output base page"}
      ]
    },
    { name: "TLB_NARROW_ENTRY_0_FLAGS",
      desc: "narrow TLB entry 0: Flags",
      swaccess: "rw",
      hwaccess: "hro",
      fields: [
        {bits: "0:0", name: "valid",  resval: 0, desc: "whether entry is valid and should be mapped"},
        {bits: "1:1", name: "read_only", resval: 0, desc: "whether entry maps read-only range"},
      ]
    },
    { reserved: 1 }

    // narrow TLB entry 1
    { name: "TLB_NARROW_ENTRY_1_PAGEIN_FIRST_LOW",
      desc: "narrow TLB entry 1: Lower 32-bit of first page number of input range",
      swaccess: "rw",
      hwaccess: "hro",
      fields: [
        {bits: "31:0", name: "PAGEIN_FIRST_LOW", desc: "Lower 32-bit of first page number of input range"}
      ]
    },
    { name: "TLB_NARROW_ENTRY_1_PAGEIN_FIRST_HIGH",
      desc: "narrow TLB entry 1: Upper 32-bit of first page number of input range",
      swaccess: "rw",
      hwaccess: "hro",
      fields: [
        {bits: "3:0", name: "PAGEIN_FIRST_HIGH", desc: "Upper 32-bit of first page number of input range"}
      ]
    },
    { name: "TLB_NARROW_ENTRY_1_PAGEIN_LAST_LOW",
      desc: "narrow TLB entry 1: Lower 32-bit of last page (inclusive) number of input range",
      swaccess: "rw",
      hwaccess: "hro",
      fields: [
        {bits: "31:0", name: "PAGEIN_LAST_LOW", desc: "Lower 32-bit of last page (inclusive) number of input range"}
      ]
    },
    { name: "TLB_NARROW_ENTRY_1_PAGEIN_LAST_HIGH",
      desc: "narrow TLB entry 1: Upper 32-bit of last page (inclusive) number of input range",
      swaccess: "rw",
      hwaccess: "hro",
      fields: [
        {bits: "3:0", name: "PAGEIN_LAST_HIGH", desc: "Upper 32-bit of last page (inclusive) number of input range"}
      ]
    },
    { name: "TLB_NARROW_ENTRY_1_PAGEOUT_LOW",
      desc: "narrow TLB entry 1: Lower 32-bit of output base page",
      swaccess: "rw",
      hwaccess: "hro",
      fields: [
        {bits: "31:0", name: "PAGEOUT_LOW", desc: "Lower 32-bit of output base page"}
      ]
    },
    { name: "TLB_NARROW_ENTRY_1_PAGEOUT_HIGH",
      desc: "narrow TLB entry 1: Upper 32-bit of output base page",
      swaccess: "rw",
      hwaccess: "hro",
      fields: [
        {bits: "3:0", name: "PAGEOUT_HIGH", desc: "Upper 32-bit of output base page"}
      ]
    },
    { name: "TLB_NARROW_ENTRY_1_FLAGS",
      desc: "narrow TLB entry 1: Flags",
      swaccess: "rw",
      hwaccess: "hro",
      fields: [
        {bits: "0:0", name: "valid",  resval: 0, desc: "whether entry is valid and should be mapped"},
        {bits: "1:1", name: "read_only", resval: 0, desc: "whether entry maps read-only range"},
      ]
    },
    { reserved: 1 }

    // narrow TLB entry 2
    { name: "TLB_NARROW_ENTRY_2_PAGEIN_FIRST_LOW",
      desc: "narrow TLB entry 2: Lower 32-bit of first page number of input range",
      swaccess: "rw",
      hwaccess: "hro",
      fields: [
        {bits: "31:0", name: "PAGEIN_FIRST_LOW", desc: "Lower 32-bit of first page number of input range"}
      ]
    },
    { name: "TLB_NARROW_ENTRY_2_PAGEIN_FIRST_HIGH",
      desc: "narrow TLB entry 2: Upper 32-bit of first page number of input range",
      swaccess: "rw",
      hwaccess: "hro",
      fields: [
        {bits: "3:0", name: "PAGEIN_FIRST_HIGH", desc: "Upper 32-bit of first page number of input range"}
      ]
    },
    { name: "TLB_NARROW_ENTRY_2_PAGEIN_LAST_LOW",
      desc: "narrow TLB entry 2: Lower 32-bit of last page (inclusive) number of input range",
      swaccess: "rw",
      hwaccess: "hro",
      fields: [
        {bits: "31:0", name: "PAGEIN_LAST_LOW", desc: "Lower 32-bit of last page (inclusive) number of input range"}
      ]
    },
    { name: "TLB_NARROW_ENTRY_2_PAGEIN_LAST_HIGH",
      desc: "narrow TLB entry 2: Upper 32-bit of last page (inclusive) number of input range",
      swaccess: "rw",
      hwaccess: "hro",
      fields: [
        {bits: "3:0", name: "PAGEIN_LAST_HIGH", desc: "Upper 32-bit of last page (inclusive) number of input range"}
      ]
    },
    { name: "TLB_NARROW_ENTRY_2_PAGEOUT_LOW",
      desc: "narrow TLB entry 2: Lower 32-bit of output base page",
      swaccess: "rw",
      hwaccess: "hro",
      fields: [
        {bits: "31:0", name: "PAGEOUT_LOW", desc: "Lower 32-bit of output base page"}
      ]
    },
    { name: "TLB_NARROW_ENTRY_2_PAGEOUT_HIGH",
      desc: "narrow TLB entry 2: Upper 32-bit of output base page",
      swaccess: "rw",
      hwaccess: "hro",
      fields: [
        {bits: "3:0", name: "PAGEOUT_HIGH", desc: "Upper 32-bit of output base page"}
      ]
    },
    { name: "TLB_NARROW_ENTRY_2_FLAGS",
      desc: "narrow TLB entry 2: Flags",
      swaccess: "rw",
      hwaccess: "hro",
      fields: [
        {bits: "0:0", name: "valid",  resval: 0, desc: "whether entry is valid and should be mapped"},
        {bits: "1:1", name: "read_only", resval: 0, desc: "whether entry maps read-only range"},
      ]
    },
    { reserved: 1 }

    // narrow TLB entry 3
    { name: "TLB_NARROW_ENTRY_3_PAGEIN_FIRST_LOW",
      desc: "narrow TLB entry 3: Lower 32-bit of first page number of input range",
      swaccess: "rw",
      hwaccess: "hro",
      fields: [
        {bits: "31:0", name: "PAGEIN_FIRST_LOW", desc: "Lower 32-bit of first page number of input range"}
      ]
    },
    { name: "TLB_NARROW_ENTRY_3_PAGEIN_FIRST_HIGH",
      desc: "narrow TLB entry 3: Upper 32-bit of first page number of input range",
      swaccess: "rw",
      hwaccess: "hro",
      fields: [
        {bits: "3:0", name: "PAGEIN_FIRST_HIGH", desc: "Upper 32-bit of first page number of input range"}
      ]
    },
    { name: "TLB_NARROW_ENTRY_3_PAGEIN_LAST_LOW",
      desc: "narrow TLB entry 3: Lower 32-bit of last page (inclusive) number of input range",
      swaccess: "rw",
      hwaccess: "hro",
      fields: [
        {bits: "31:0", name: "PAGEIN_LAST_LOW", desc: "Lower 32-bit of last page (inclusive) number of input range"}
      ]
    },
    { name: "TLB_NARROW_ENTRY_3_PAGEIN_LAST_HIGH",
      desc: "narrow TLB entry 3: Upper 32-bit of last page (inclusive) number of input range",
      swaccess: "rw",
      hwaccess: "hro",
      fields: [
        {bits: "3:0", name: "PAGEIN_LAST_HIGH", desc: "Upper 32-bit of last page (inclusive) number of input range"}
      ]
    },
    { name: "TLB_NARROW_ENTRY_3_PAGEOUT_LOW",
      desc: "narrow TLB entry 3: Lower 32-bit of output base page",
      swaccess: "rw",
      hwaccess: "hro",
      fields: [
        {bits: "31:0", name: "PAGEOUT_LOW", desc: "Lower 32-bit of output base page"}
      ]
    },
    { name: "TLB_NARROW_ENTRY_3_PAGEOUT_HIGH",
      desc: "narrow TLB entry 3: Upper 32-bit of output base page",
      swaccess: "rw",
      hwaccess: "hro",
      fields: [
        {bits: "3:0", name: "PAGEOUT_HIGH", desc: "Upper 32-bit of output base page"}
      ]
    },
    { name: "TLB_NARROW_ENTRY_3_FLAGS",
      desc: "narrow TLB entry 3: Flags",
      swaccess: "rw",
      hwaccess: "hro",
      fields: [
        {bits: "0:0", name: "valid",  resval: 0, desc: "whether entry is valid and should be mapped"},
        {bits: "1:1", name: "read_only", resval: 0, desc: "whether entry maps read-only range"},
      ]
    },
    { reserved: 1 }

    // narrow TLB entry 4
    { name: "TLB_NARROW_ENTRY_4_PAGEIN_FIRST_LOW",
      desc: "narrow TLB entry 4: Lower 32-bit of first page number of input range",
      swaccess: "rw",
      hwaccess: "hro",
      fields: [
        {bits: "31:0", name: "PAGEIN_FIRST_LOW", desc: "Lower 32-bit of first page number of input range"}
      ]
    },
    { name: "TLB_NARROW_ENTRY_4_PAGEIN_FIRST_HIGH",
      desc: "narrow TLB entry 4: Upper 32-bit of first page number of input range",
      swaccess: "rw",
      hwaccess: "hro",
      fields: [
        {bits: "3:0", name: "PAGEIN_FIRST_HIGH", desc: "Upper 32-bit of first page number of input range"}
      ]
    },
    { name: "TLB_NARROW_ENTRY_4_PAGEIN_LAST_LOW",
      desc: "narrow TLB entry 4: Lower 32-bit of last page (inclusive) number of input range",
      swaccess: "rw",
      hwaccess: "hro",
      fields: [
        {bits: "31:0", name: "PAGEIN_LAST_LOW", desc: "Lower 32-bit of last page (inclusive) number of input range"}
      ]
    },
    { name: "TLB_NARROW_ENTRY_4_PAGEIN_LAST_HIGH",
      desc: "narrow TLB entry 4: Upper 32-bit of last page (inclusive) number of input range",
      swaccess: "rw",
      hwaccess: "hro",
      fields: [
        {bits: "3:0", name: "PAGEIN_LAST_HIGH", desc: "Upper 32-bit of last page (inclusive) number of input range"}
      ]
    },
    { name: "TLB_NARROW_ENTRY_4_PAGEOUT_LOW",
      desc: "narrow TLB entry 4: Lower 32-bit of output base page",
      swaccess: "rw",
      hwaccess: "hro",
      fields: [
        {bits: "31:0", name: "PAGEOUT_LOW", desc: "Lower 32-bit of output base page"}
      ]
    },
    { name: "TLB_NARROW_ENTRY_4_PAGEOUT_HIGH",
      desc: "narrow TLB entry 4: Upper 32-bit of output base page",
      swaccess: "rw",
      hwaccess: "hro",
      fields: [
        {bits: "3:0", name: "PAGEOUT_HIGH", desc: "Upper 32-bit of output base page"}
      ]
    },
    { name: "TLB_NARROW_ENTRY_4_FLAGS",
      desc: "narrow TLB entry 4: Flags",
      swaccess: "rw",
      hwaccess: "hro",
      fields: [
        {bits: "0:0", name: "valid",  resval: 0, desc: "whether entry is valid and should be mapped"},
        {bits: "1:1", name: "read_only", resval: 0, desc: "whether entry maps read-only range"},
      ]
    },
    { reserved: 1 }

    // narrow TLB entry 5
    { name: "TLB_NARROW_ENTRY_5_PAGEIN_FIRST_LOW",
      desc: "narrow TLB entry 5: Lower 32-bit of first page number of input range",
      swaccess: "rw",
      hwaccess: "hro",
      fields: [
        {bits: "31:0", name: "PAGEIN_FIRST_LOW", desc: "Lower 32-bit of first page number of input range"}
      ]
    },
    { name: "TLB_NARROW_ENTRY_5_PAGEIN_FIRST_HIGH",
      desc: "narrow TLB entry 5: Upper 32-bit of first page number of input range",
      swaccess: "rw",
      hwaccess: "hro",
      fields: [
        {bits: "3:0", name: "PAGEIN_FIRST_HIGH", desc: "Upper 32-bit of first page number of input range"}
      ]
    },
    { name: "TLB_NARROW_ENTRY_5_PAGEIN_LAST_LOW",
      desc: "narrow TLB entry 5: Lower 32-bit of last page (inclusive) number of input range",
      swaccess: "rw",
      hwaccess: "hro",
      fields: [
        {bits: "31:0", name: "PAGEIN_LAST_LOW", desc: "Lower 32-bit of last page (inclusive) number of input range"}
      ]
    },
    { name: "TLB_NARROW_ENTRY_5_PAGEIN_LAST_HIGH",
      desc: "narrow TLB entry 5: Upper 32-bit of last page (inclusive) number of input range",
      swaccess: "rw",
      hwaccess: "hro",
      fields: [
        {bits: "3:0", name: "PAGEIN_LAST_HIGH", desc: "Upper 32-bit of last page (inclusive) number of input range"}
      ]
    },
    { name: "TLB_NARROW_ENTRY_5_PAGEOUT_LOW",
      desc: "narrow TLB entry 5: Lower 32-bit of output base page",
      swaccess: "rw",
      hwaccess: "hro",
      fields: [
        {bits: "31:0", name: "PAGEOUT_LOW", desc: "Lower 32-bit of output base page"}
      ]
    },
    { name: "TLB_NARROW_ENTRY_5_PAGEOUT_HIGH",
      desc: "narrow TLB entry 5: Upper 32-bit of output base page",
      swaccess: "rw",
      hwaccess: "hro",
      fields: [
        {bits: "3:0", name: "PAGEOUT_HIGH", desc: "Upper 32-bit of output base page"}
      ]
    },
    { name: "TLB_NARROW_ENTRY_5_FLAGS",
      desc: "narrow TLB entry 5: Flags",
      swaccess: "rw",
      hwaccess: "hro",
      fields: [
        {bits: "0:0", name: "valid",  resval: 0, desc: "whether entry is valid and should be mapped"},
        {bits: "1:1", name: "read_only", resval: 0, desc: "whether entry maps read-only range"},
      ]
    },
    { reserved: 1 }

    // narrow TLB entry 6
    { name: "TLB_NARROW_ENTRY_6_PAGEIN_FIRST_LOW",
      desc: "narrow TLB entry 6: Lower 32-bit of first page number of input range",
      swaccess: "rw",
      hwaccess: "hro",
      fields: [
        {bits: "31:0", name: "PAGEIN_FIRST_LOW", desc: "Lower 32-bit of first page number of input range"}
      ]
    },
    { name: "TLB_NARROW_ENTRY_6_PAGEIN_FIRST_HIGH",
      desc: "narrow TLB entry 6: Upper 32-bit of first page number of input range",
      swaccess: "rw",
      hwaccess: "hro",
      fields: [
        {bits: "3:0", name: "PAGEIN_FIRST_HIGH", desc: "Upper 32-bit of first page number of input range"}
      ]
    },
    { name: "TLB_NARROW_ENTRY_6_PAGEIN_LAST_LOW",
      desc: "narrow TLB entry 6: Lower 32-bit of last page (inclusive) number of input range",
      swaccess: "rw",
      hwaccess: "hro",
      fields: [
        {bits: "31:0", name: "PAGEIN_LAST_LOW", desc: "Lower 32-bit of last page (inclusive) number of input range"}
      ]
    },
    { name: "TLB_NARROW_ENTRY_6_PAGEIN_LAST_HIGH",
      desc: "narrow TLB entry 6: Upper 32-bit of last page (inclusive) number of input range",
      swaccess: "rw",
      hwaccess: "hro",
      fields: [
        {bits: "3:0", name: "PAGEIN_LAST_HIGH", desc: "Upper 32-bit of last page (inclusive) number of input range"}
      ]
    },
    { name: "TLB_NARROW_ENTRY_6_PAGEOUT_LOW",
      desc: "narrow TLB entry 6: Lower 32-bit of output base page",
      swaccess: "rw",
      hwaccess: "hro",
      fields: [
        {bits: "31:0", name: "PAGEOUT_LOW", desc: "Lower 32-bit of output base page"}
      ]
    },
    { name: "TLB_NARROW_ENTRY_6_PAGEOUT_HIGH",
      desc: "narrow TLB entry 6: Upper 32-bit of output base page",
      swaccess: "rw",
      hwaccess: "hro",
      fields: [
        {bits: "3:0", name: "PAGEOUT_HIGH", desc: "Upper 32-bit of output base page"}
      ]
    },
    { name: "TLB_NARROW_ENTRY_6_FLAGS",
      desc: "narrow TLB entry 6: Flags",
      swaccess: "rw",
      hwaccess: "hro",
      fields: [
        {bits: "0:0", name: "valid",  resval: 0, desc: "whether entry is valid and should be mapped"},
        {bits: "1:1", name: "read_only", resval: 0, desc: "whether entry maps read-only range"},
      ]
    },
    { reserved: 1 }

    // narrow TLB entry 7
    { name: "TLB_NARROW_ENTRY_7_PAGEIN_FIRST_LOW",
      desc: "narrow TLB entry 7: Lower 32-bit of first page number of input range",
      swaccess: "rw",
      hwaccess: "hro",
      fields: [
        {bits: "31:0", name: "PAGEIN_FIRST_LOW", desc: "Lower 32-bit of first page number of input range"}
      ]
    },
    { name: "TLB_NARROW_ENTRY_7_PAGEIN_FIRST_HIGH",
      desc: "narrow TLB entry 7: Upper 32-bit of first page number of input range",
      swaccess: "rw",
      hwaccess: "hro",
      fields: [
        {bits: "3:0", name: "PAGEIN_FIRST_HIGH", desc: "Upper 32-bit of first page number of input range"}
      ]
    },
    { name: "TLB_NARROW_ENTRY_7_PAGEIN_LAST_LOW",
      desc: "narrow TLB entry 7: Lower 32-bit of last page (inclusive) number of input range",
      swaccess: "rw",
      hwaccess: "hro",
      fields: [
        {bits: "31:0", name: "PAGEIN_LAST_LOW", desc: "Lower 32-bit of last page (inclusive) number of input range"}
      ]
    },
    { name: "TLB_NARROW_ENTRY_7_PAGEIN_LAST_HIGH",
      desc: "narrow TLB entry 7: Upper 32-bit of last page (inclusive) number of input range",
      swaccess: "rw",
      hwaccess: "hro",
      fields: [
        {bits: "3:0", name: "PAGEIN_LAST_HIGH", desc: "Upper 32-bit of last page (inclusive) number of input range"}
      ]
    },
    { name: "TLB_NARROW_ENTRY_7_PAGEOUT_LOW",
      desc: "narrow TLB entry 7: Lower 32-bit of output base page",
      swaccess: "rw",
      hwaccess: "hro",
      fields: [
        {bits: "31:0", name: "PAGEOUT_LOW", desc: "Lower 32-bit of output base page"}
      ]
    },
    { name: "TLB_NARROW_ENTRY_7_PAGEOUT_HIGH",
      desc: "narrow TLB entry 7: Upper 32-bit of output base page",
      swaccess: "rw",
      hwaccess: "hro",
      fields: [
        {bits: "3:0", name: "PAGEOUT_HIGH", desc: "Upper 32-bit of output base page"}
      ]
    },
    { name: "TLB_NARROW_ENTRY_7_FLAGS",
      desc: "narrow TLB entry 7: Flags",
      swaccess: "rw",
      hwaccess: "hro",
      fields: [
        {bits: "0:0", name: "valid",  resval: 0, desc: "whether entry is valid and should be mapped"},
        {bits: "1:1", name: "read_only", resval: 0, desc: "whether entry maps read-only range"},
      ]
    },
    { reserved: 1 }
    // Start wide TLB fields at regular offset
    { skipto: "0x1000" }

    // wide TLB entry 0
    { name: "TLB_WIDE_ENTRY_0_PAGEIN_FIRST_LOW",
      desc: "wide TLB entry 0: Lower 32-bit of first page number of input range",
      swaccess: "rw",
      hwaccess: "hro",
      fields: [
        {bits: "31:0", name: "PAGEIN_FIRST_LOW", desc: "Lower 32-bit of first page number of input range"}
      ]
    },
    { name: "TLB_WIDE_ENTRY_0_PAGEIN_FIRST_HIGH",
      desc: "wide TLB entry 0: Upper 32-bit of first page number of input range",
      swaccess: "rw",
      hwaccess: "hro",
      fields: [
        {bits: "3:0", name: "PAGEIN_FIRST_HIGH", desc: "Upper 32-bit of first page number of input range"}
      ]
    },
    { name: "TLB_WIDE_ENTRY_0_PAGEIN_LAST_LOW",
      desc: "wide TLB entry 0: Lower 32-bit of last page (inclusive) number of input range",
      swaccess: "rw",
      hwaccess: "hro",
      fields: [
        {bits: "31:0", name: "PAGEIN_LAST_LOW", desc: "Lower 32-bit of last page (inclusive) number of input range"}
      ]
    },
    { name: "TLB_WIDE_ENTRY_0_PAGEIN_LAST_HIGH",
      desc: "wide TLB entry 0: Upper 32-bit of last page (inclusive) number of input range",
      swaccess: "rw",
      hwaccess: "hro",
      fields: [
        {bits: "3:0", name: "PAGEIN_LAST_HIGH", desc: "Upper 32-bit of last page (inclusive) number of input range"}
      ]
    },
    { name: "TLB_WIDE_ENTRY_0_PAGEOUT_LOW",
      desc: "wide TLB entry 0: Lower 32-bit of output base page",
      swaccess: "rw",
      hwaccess: "hro",
      fields: [
        {bits: "31:0", name: "PAGEOUT_LOW", desc: "Lower 32-bit of output base page"}
      ]
    },
    { name: "TLB_WIDE_ENTRY_0_PAGEOUT_HIGH",
      desc: "wide TLB entry 0: Upper 32-bit of output base page",
      swaccess: "rw",
      hwaccess: "hro",
      fields: [
        {bits: "3:0", name: "PAGEOUT_HIGH", desc: "Upper 32-bit of output base page"}
      ]
    },
    { name: "TLB_WIDE_ENTRY_0_FLAGS",
      desc: "wide TLB entry 0: Flags",
      swaccess: "rw",
      hwaccess: "hro",
      fields: [
        {bits: "0:0", name: "valid",  resval: 0, desc: "whether entry is valid and should be mapped"},
        {bits: "1:1", name: "read_only", resval: 0, desc: "whether entry maps read-only range"},
      ]
    },
    { reserved: 1 }

    // wide TLB entry 1
    { name: "TLB_WIDE_ENTRY_1_PAGEIN_FIRST_LOW",
      desc: "wide TLB entry 1: Lower 32-bit of first page number of input range",
      swaccess: "rw",
      hwaccess: "hro",
      fields: [
        {bits: "31:0", name: "PAGEIN_FIRST_LOW", desc: "Lower 32-bit of first page number of input range"}
      ]
    },
    { name: "TLB_WIDE_ENTRY_1_PAGEIN_FIRST_HIGH",
      desc: "wide TLB entry 1: Upper 32-bit of first page number of input range",
      swaccess: "rw",
      hwaccess: "hro",
      fields: [
        {bits: "3:0", name: "PAGEIN_FIRST_HIGH", desc: "Upper 32-bit of first page number of input range"}
      ]
    },
    { name: "TLB_WIDE_ENTRY_1_PAGEIN_LAST_LOW",
      desc: "wide TLB entry 1: Lower 32-bit of last page (inclusive) number of input range",
      swaccess: "rw",
      hwaccess: "hro",
      fields: [
        {bits: "31:0", name: "PAGEIN_LAST_LOW", desc: "Lower 32-bit of last page (inclusive) number of input range"}
      ]
    },
    { name: "TLB_WIDE_ENTRY_1_PAGEIN_LAST_HIGH",
      desc: "wide TLB entry 1: Upper 32-bit of last page (inclusive) number of input range",
      swaccess: "rw",
      hwaccess: "hro",
      fields: [
        {bits: "3:0", name: "PAGEIN_LAST_HIGH", desc: "Upper 32-bit of last page (inclusive) number of input range"}
      ]
    },
    { name: "TLB_WIDE_ENTRY_1_PAGEOUT_LOW",
      desc: "wide TLB entry 1: Lower 32-bit of output base page",
      swaccess: "rw",
      hwaccess: "hro",
      fields: [
        {bits: "31:0", name: "PAGEOUT_LOW", desc: "Lower 32-bit of output base page"}
      ]
    },
    { name: "TLB_WIDE_ENTRY_1_PAGEOUT_HIGH",
      desc: "wide TLB entry 1: Upper 32-bit of output base page",
      swaccess: "rw",
      hwaccess: "hro",
      fields: [
        {bits: "3:0", name: "PAGEOUT_HIGH", desc: "Upper 32-bit of output base page"}
      ]
    },
    { name: "TLB_WIDE_ENTRY_1_FLAGS",
      desc: "wide TLB entry 1: Flags",
      swaccess: "rw",
      hwaccess: "hro",
      fields: [
        {bits: "0:0", name: "valid",  resval: 0, desc: "whether entry is valid and should be mapped"},
        {bits: "1:1", name: "read_only", resval: 0, desc: "whether entry maps read-only range"},
      ]
    },
    { reserved: 1 }

    // wide TLB entry 2
    { name: "TLB_WIDE_ENTRY_2_PAGEIN_FIRST_LOW",
      desc: "wide TLB entry 2: Lower 32-bit of first page number of input range",
      swaccess: "rw",
      hwaccess: "hro",
      fields: [
        {bits: "31:0", name: "PAGEIN_FIRST_LOW", desc: "Lower 32-bit of first page number of input range"}
      ]
    },
    { name: "TLB_WIDE_ENTRY_2_PAGEIN_FIRST_HIGH",
      desc: "wide TLB entry 2: Upper 32-bit of first page number of input range",
      swaccess: "rw",
      hwaccess: "hro",
      fields: [
        {bits: "3:0", name: "PAGEIN_FIRST_HIGH", desc: "Upper 32-bit of first page number of input range"}
      ]
    },
    { name: "TLB_WIDE_ENTRY_2_PAGEIN_LAST_LOW",
      desc: "wide TLB entry 2: Lower 32-bit of last page (inclusive) number of input range",
      swaccess: "rw",
      hwaccess: "hro",
      fields: [
        {bits: "31:0", name: "PAGEIN_LAST_LOW", desc: "Lower 32-bit of last page (inclusive) number of input range"}
      ]
    },
    { name: "TLB_WIDE_ENTRY_2_PAGEIN_LAST_HIGH",
      desc: "wide TLB entry 2: Upper 32-bit of last page (inclusive) number of input range",
      swaccess: "rw",
      hwaccess: "hro",
      fields: [
        {bits: "3:0", name: "PAGEIN_LAST_HIGH", desc: "Upper 32-bit of last page (inclusive) number of input range"}
      ]
    },
    { name: "TLB_WIDE_ENTRY_2_PAGEOUT_LOW",
      desc: "wide TLB entry 2: Lower 32-bit of output base page",
      swaccess: "rw",
      hwaccess: "hro",
      fields: [
        {bits: "31:0", name: "PAGEOUT_LOW", desc: "Lower 32-bit of output base page"}
      ]
    },
    { name: "TLB_WIDE_ENTRY_2_PAGEOUT_HIGH",
      desc: "wide TLB entry 2: Upper 32-bit of output base page",
      swaccess: "rw",
      hwaccess: "hro",
      fields: [
        {bits: "3:0", name: "PAGEOUT_HIGH", desc: "Upper 32-bit of output base page"}
      ]
    },
    { name: "TLB_WIDE_ENTRY_2_FLAGS",
      desc: "wide TLB entry 2: Flags",
      swaccess: "rw",
      hwaccess: "hro",
      fields: [
        {bits: "0:0", name: "valid",  resval: 0, desc: "whether entry is valid and should be mapped"},
        {bits: "1:1", name: "read_only", resval: 0, desc: "whether entry maps read-only range"},
      ]
    },
    { reserved: 1 }

    // wide TLB entry 3
    { name: "TLB_WIDE_ENTRY_3_PAGEIN_FIRST_LOW",
      desc: "wide TLB entry 3: Lower 32-bit of first page number of input range",
      swaccess: "rw",
      hwaccess: "hro",
      fields: [
        {bits: "31:0", name: "PAGEIN_FIRST_LOW", desc: "Lower 32-bit of first page number of input range"}
      ]
    },
    { name: "TLB_WIDE_ENTRY_3_PAGEIN_FIRST_HIGH",
      desc: "wide TLB entry 3: Upper 32-bit of first page number of input range",
      swaccess: "rw",
      hwaccess: "hro",
      fields: [
        {bits: "3:0", name: "PAGEIN_FIRST_HIGH", desc: "Upper 32-bit of first page number of input range"}
      ]
    },
    { name: "TLB_WIDE_ENTRY_3_PAGEIN_LAST_LOW",
      desc: "wide TLB entry 3: Lower 32-bit of last page (inclusive) number of input range",
      swaccess: "rw",
      hwaccess: "hro",
      fields: [
        {bits: "31:0", name: "PAGEIN_LAST_LOW", desc: "Lower 32-bit of last page (inclusive) number of input range"}
      ]
    },
    { name: "TLB_WIDE_ENTRY_3_PAGEIN_LAST_HIGH",
      desc: "wide TLB entry 3: Upper 32-bit of last page (inclusive) number of input range",
      swaccess: "rw",
      hwaccess: "hro",
      fields: [
        {bits: "3:0", name: "PAGEIN_LAST_HIGH", desc: "Upper 32-bit of last page (inclusive) number of input range"}
      ]
    },
    { name: "TLB_WIDE_ENTRY_3_PAGEOUT_LOW",
      desc: "wide TLB entry 3: Lower 32-bit of output base page",
      swaccess: "rw",
      hwaccess: "hro",
      fields: [
        {bits: "31:0", name: "PAGEOUT_LOW", desc: "Lower 32-bit of output base page"}
      ]
    },
    { name: "TLB_WIDE_ENTRY_3_PAGEOUT_HIGH",
      desc: "wide TLB entry 3: Upper 32-bit of output base page",
      swaccess: "rw",
      hwaccess: "hro",
      fields: [
        {bits: "3:0", name: "PAGEOUT_HIGH", desc: "Upper 32-bit of output base page"}
      ]
    },
    { name: "TLB_WIDE_ENTRY_3_FLAGS",
      desc: "wide TLB entry 3: Flags",
      swaccess: "rw",
      hwaccess: "hro",
      fields: [
        {bits: "0:0", name: "valid",  resval: 0, desc: "whether entry is valid and should be mapped"},
        {bits: "1:1", name: "read_only", resval: 0, desc: "whether entry maps read-only range"},
      ]
    },
    { reserved: 1 }

    // wide TLB entry 4
    { name: "TLB_WIDE_ENTRY_4_PAGEIN_FIRST_LOW",
      desc: "wide TLB entry 4: Lower 32-bit of first page number of input range",
      swaccess: "rw",
      hwaccess: "hro",
      fields: [
        {bits: "31:0", name: "PAGEIN_FIRST_LOW", desc: "Lower 32-bit of first page number of input range"}
      ]
    },
    { name: "TLB_WIDE_ENTRY_4_PAGEIN_FIRST_HIGH",
      desc: "wide TLB entry 4: Upper 32-bit of first page number of input range",
      swaccess: "rw",
      hwaccess: "hro",
      fields: [
        {bits: "3:0", name: "PAGEIN_FIRST_HIGH", desc: "Upper 32-bit of first page number of input range"}
      ]
    },
    { name: "TLB_WIDE_ENTRY_4_PAGEIN_LAST_LOW",
      desc: "wide TLB entry 4: Lower 32-bit of last page (inclusive) number of input range",
      swaccess: "rw",
      hwaccess: "hro",
      fields: [
        {bits: "31:0", name: "PAGEIN_LAST_LOW", desc: "Lower 32-bit of last page (inclusive) number of input range"}
      ]
    },
    { name: "TLB_WIDE_ENTRY_4_PAGEIN_LAST_HIGH",
      desc: "wide TLB entry 4: Upper 32-bit of last page (inclusive) number of input range",
      swaccess: "rw",
      hwaccess: "hro",
      fields: [
        {bits: "3:0", name: "PAGEIN_LAST_HIGH", desc: "Upper 32-bit of last page (inclusive) number of input range"}
      ]
    },
    { name: "TLB_WIDE_ENTRY_4_PAGEOUT_LOW",
      desc: "wide TLB entry 4: Lower 32-bit of output base page",
      swaccess: "rw",
      hwaccess: "hro",
      fields: [
        {bits: "31:0", name: "PAGEOUT_LOW", desc: "Lower 32-bit of output base page"}
      ]
    },
    { name: "TLB_WIDE_ENTRY_4_PAGEOUT_HIGH",
      desc: "wide TLB entry 4: Upper 32-bit of output base page",
      swaccess: "rw",
      hwaccess: "hro",
      fields: [
        {bits: "3:0", name: "PAGEOUT_HIGH", desc: "Upper 32-bit of output base page"}
      ]
    },
    { name: "TLB_WIDE_ENTRY_4_FLAGS",
      desc: "wide TLB entry 4: Flags",
      swaccess: "rw",
      hwaccess: "hro",
      fields: [
        {bits: "0:0", name: "valid",  resval: 0, desc: "whether entry is valid and should be mapped"},
        {bits: "1:1", name: "read_only", resval: 0, desc: "whether entry maps read-only range"},
      ]
    },
    { reserved: 1 }

    // wide TLB entry 5
    { name: "TLB_WIDE_ENTRY_5_PAGEIN_FIRST_LOW",
      desc: "wide TLB entry 5: Lower 32-bit of first page number of input range",
      swaccess: "rw",
      hwaccess: "hro",
      fields: [
        {bits: "31:0", name: "PAGEIN_FIRST_LOW", desc: "Lower 32-bit of first page number of input range"}
      ]
    },
    { name: "TLB_WIDE_ENTRY_5_PAGEIN_FIRST_HIGH",
      desc: "wide TLB entry 5: Upper 32-bit of first page number of input range",
      swaccess: "rw",
      hwaccess: "hro",
      fields: [
        {bits: "3:0", name: "PAGEIN_FIRST_HIGH", desc: "Upper 32-bit of first page number of input range"}
      ]
    },
    { name: "TLB_WIDE_ENTRY_5_PAGEIN_LAST_LOW",
      desc: "wide TLB entry 5: Lower 32-bit of last page (inclusive) number of input range",
      swaccess: "rw",
      hwaccess: "hro",
      fields: [
        {bits: "31:0", name: "PAGEIN_LAST_LOW", desc: "Lower 32-bit of last page (inclusive) number of input range"}
      ]
    },
    { name: "TLB_WIDE_ENTRY_5_PAGEIN_LAST_HIGH",
      desc: "wide TLB entry 5: Upper 32-bit of last page (inclusive) number of input range",
      swaccess: "rw",
      hwaccess: "hro",
      fields: [
        {bits: "3:0", name: "PAGEIN_LAST_HIGH", desc: "Upper 32-bit of last page (inclusive) number of input range"}
      ]
    },
    { name: "TLB_WIDE_ENTRY_5_PAGEOUT_LOW",
      desc: "wide TLB entry 5: Lower 32-bit of output base page",
      swaccess: "rw",
      hwaccess: "hro",
      fields: [
        {bits: "31:0", name: "PAGEOUT_LOW", desc: "Lower 32-bit of output base page"}
      ]
    },
    { name: "TLB_WIDE_ENTRY_5_PAGEOUT_HIGH",
      desc: "wide TLB entry 5: Upper 32-bit of output base page",
      swaccess: "rw",
      hwaccess: "hro",
      fields: [
        {bits: "3:0", name: "PAGEOUT_HIGH", desc: "Upper 32-bit of output base page"}
      ]
    },
    { name: "TLB_WIDE_ENTRY_5_FLAGS",
      desc: "wide TLB entry 5: Flags",
      swaccess: "rw",
      hwaccess: "hro",
      fields: [
        {bits: "0:0", name: "valid",  resval: 0, desc: "whether entry is valid and should be mapped"},
        {bits: "1:1", name: "read_only", resval: 0, desc: "whether entry maps read-only range"},
      ]
    },
    { reserved: 1 }

    // wide TLB entry 6
    { name: "TLB_WIDE_ENTRY_6_PAGEIN_FIRST_LOW",
      desc: "wide TLB entry 6: Lower 32-bit of first page number of input range",
      swaccess: "rw",
      hwaccess: "hro",
      fields: [
        {bits: "31:0", name: "PAGEIN_FIRST_LOW", desc: "Lower 32-bit of first page number of input range"}
      ]
    },
    { name: "TLB_WIDE_ENTRY_6_PAGEIN_FIRST_HIGH",
      desc: "wide TLB entry 6: Upper 32-bit of first page number of input range",
      swaccess: "rw",
      hwaccess: "hro",
      fields: [
        {bits: "3:0", name: "PAGEIN_FIRST_HIGH", desc: "Upper 32-bit of first page number of input range"}
      ]
    },
    { name: "TLB_WIDE_ENTRY_6_PAGEIN_LAST_LOW",
      desc: "wide TLB entry 6: Lower 32-bit of last page (inclusive) number of input range",
      swaccess: "rw",
      hwaccess: "hro",
      fields: [
        {bits: "31:0", name: "PAGEIN_LAST_LOW", desc: "Lower 32-bit of last page (inclusive) number of input range"}
      ]
    },
    { name: "TLB_WIDE_ENTRY_6_PAGEIN_LAST_HIGH",
      desc: "wide TLB entry 6: Upper 32-bit of last page (inclusive) number of input range",
      swaccess: "rw",
      hwaccess: "hro",
      fields: [
        {bits: "3:0", name: "PAGEIN_LAST_HIGH", desc: "Upper 32-bit of last page (inclusive) number of input range"}
      ]
    },
    { name: "TLB_WIDE_ENTRY_6_PAGEOUT_LOW",
      desc: "wide TLB entry 6: Lower 32-bit of output base page",
      swaccess: "rw",
      hwaccess: "hro",
      fields: [
        {bits: "31:0", name: "PAGEOUT_LOW", desc: "Lower 32-bit of output base page"}
      ]
    },
    { name: "TLB_WIDE_ENTRY_6_PAGEOUT_HIGH",
      desc: "wide TLB entry 6: Upper 32-bit of output base page",
      swaccess: "rw",
      hwaccess: "hro",
      fields: [
        {bits: "3:0", name: "PAGEOUT_HIGH", desc: "Upper 32-bit of output base page"}
      ]
    },
    { name: "TLB_WIDE_ENTRY_6_FLAGS",
      desc: "wide TLB entry 6: Flags",
      swaccess: "rw",
      hwaccess: "hro",
      fields: [
        {bits: "0:0", name: "valid",  resval: 0, desc: "whether entry is valid and should be mapped"},
        {bits: "1:1", name: "read_only", resval: 0, desc: "whether entry maps read-only range"},
      ]
    },
    { reserved: 1 }

    // wide TLB entry 7
    { name: "TLB_WIDE_ENTRY_7_PAGEIN_FIRST_LOW",
      desc: "wide TLB entry 7: Lower 32-bit of first page number of input range",
      swaccess: "rw",
      hwaccess: "hro",
      fields: [
        {bits: "31:0", name: "PAGEIN_FIRST_LOW", desc: "Lower 32-bit of first page number of input range"}
      ]
    },
    { name: "TLB_WIDE_ENTRY_7_PAGEIN_FIRST_HIGH",
      desc: "wide TLB entry 7: Upper 32-bit of first page number of input range",
      swaccess: "rw",
      hwaccess: "hro",
      fields: [
        {bits: "3:0", name: "PAGEIN_FIRST_HIGH", desc: "Upper 32-bit of first page number of input range"}
      ]
    },
    { name: "TLB_WIDE_ENTRY_7_PAGEIN_LAST_LOW",
      desc: "wide TLB entry 7: Lower 32-bit of last page (inclusive) number of input range",
      swaccess: "rw",
      hwaccess: "hro",
      fields: [
        {bits: "31:0", name: "PAGEIN_LAST_LOW", desc: "Lower 32-bit of last page (inclusive) number of input range"}
      ]
    },
    { name: "TLB_WIDE_ENTRY_7_PAGEIN_LAST_HIGH",
      desc: "wide TLB entry 7: Upper 32-bit of last page (inclusive) number of input range",
      swaccess: "rw",
      hwaccess: "hro",
      fields: [
        {bits: "3:0", name: "PAGEIN_LAST_HIGH", desc: "Upper 32-bit of last page (inclusive) number of input range"}
      ]
    },
    { name: "TLB_WIDE_ENTRY_7_PAGEOUT_LOW",
      desc: "wide TLB entry 7: Lower 32-bit of output base page",
      swaccess: "rw",
      hwaccess: "hro",
      fields: [
        {bits: "31:0", name: "PAGEOUT_LOW", desc: "Lower 32-bit of output base page"}
      ]
    },
    { name: "TLB_WIDE_ENTRY_7_PAGEOUT_HIGH",
      desc: "wide TLB entry 7: Upper 32-bit of output base page",
      swaccess: "rw",
      hwaccess: "hro",
      fields: [
        {bits: "3:0", name: "PAGEOUT_HIGH", desc: "Upper 32-bit of output base page"}
      ]
    },
    { name: "TLB_WIDE_ENTRY_7_FLAGS",
      desc: "wide TLB entry 7: Flags",
      swaccess: "rw",
      hwaccess: "hro",
      fields: [
        {bits: "0:0", name: "valid",  resval: 0, desc: "whether entry is valid and should be mapped"},
        {bits: "1:1", name: "read_only", resval: 0, desc: "whether entry maps read-only range"},
      ]
    },
    { reserved: 1 }



  ]
}
